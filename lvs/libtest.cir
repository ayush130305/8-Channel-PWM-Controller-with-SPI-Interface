* libtest from /home/ayush-jain/Desktop/pwm8_spi/pnr/libtest/libtest_rt.v by flow/v2spice.py
.SUBCKT libtest clk in0 in1 in2 in3 in4 in5 out0 out1 out2 out3 out4 out5 out6 out7 rst_n VDD VSS
Xu0 in0 in3 in0 n0 VDD VSS ADNR01
Xu1 in2 in5 in1 n1 VDD VSS ADNR01
Xu10 clknet_1_0__leaf_clk in2 rst_n n13 n12 VSS VDD DFCL11
Xu100 clknet_1_1__leaf_clk n91 rst_n n109 n108 VSS VDD DFCL11
Xu101 n84 n110 VDD VSS INVR01
Xu102 VDD n111 VDD VSS INVR01
Xu103 n80 n112 VDD VSS INVR05
Xu104 n78 n113 VDD VSS INVR05
Xu105 n79 n81 n114 VDD VDD VSS MX2101
Xu106 VDD n85 n115 n86 VDD VSS MX2101
Xu107 n84 n87 n116 VSS VDD NND201
Xu108 n85 n88 n117 VSS VDD NND201
Xu109 n86 n89 n92 n101 n98 n95 n118 VSS VDD NND601
Xu11 n12 n14 VDD VSS INVR01
Xu110 n99 n102 n105 n114 n111 n108 n119 VSS VDD NND601
Xu111 n112 n115 n120 VDD VSS NOR200
Xu112 n113 n116 n121 VDD VSS NOR200
Xu113 n114 n117 n120 n122 VDD VSS NOR300
Xu114 n118 n121 in0 n123 VDD VSS NOR300
Xu115 n3 n0 in3 in0 n122 n124 VDD VSS NOR501
Xu116 n12 n9 n6 n3 n0 n125 VDD VSS NOR501
Xu117 n9 n12 n126 VSS VDD OR2101
Xu118 n9 n12 n127 VSS VDD OR2101
Xu119 n15 n18 n21 n128 VSS VDD ORND01
Xu12 n12 n15 VDD VSS INVR01
Xu120 n18 n21 n24 n129 VSS VDD ORND01
Xu121 VDD VSS VDDCON
Xu122 VDD VSS VDDCON
Xu123 n3 n6 n132 VSS VDD XNR201
Xu124 n3 n6 n133 VSS VDD XNR201
Xu125 n3 n6 n134 VSS VDD XOR201
Xu126 n3 n6 n135 VSS VDD XOR201
Xu127 n3 n136 VDD VSS CDRI01
Xu128 n0 n137 VDD VSS CDRI01
Xu129 in3 n138 VSS VDD INVR02
Xu13 n12 n16 VDD VSS INVR05
Xu130 in0 n139 VSS VDD INVR02
Xu131 n138 n140 VSS VDD INVR04
Xu132 n136 n141 VSS VDD INVR04
Xu133 n134 n142 VSS VDD INVR06
Xu134 n132 n143 VSS VDD INVR06
Xu135 n135 n138 n141 n144 VDD VSS ADNR01
Xu136 n139 n142 in0 n145 VDD VSS ADNR01
Xu137 n138 n141 n146 VSS VDD AND201
Xu138 n139 n142 n147 VSS VDD AND201
Xu139 n146 n143 n140 n148 VDD VSS AND301
Xu14 n12 n17 VDD VSS INVR05
Xu140 in0 n147 n144 n149 VDD VSS AND301
Xu141 in3 n0 n3 n6 n150 VDD VSS AOI401
Xu142 n3 n6 n9 n12 n151 VDD VSS AOI401
Xu143 clknet_1_0__leaf_clk n3 rst_n n153 n152 VSS VDD DFCL11
Xu144 clknet_1_0__leaf_clk in0 rst_n n155 n154 VSS VDD DFCL11
Xu145 clknet_1_0__leaf_clk n148 rst_n n157 n156 VSS VDD DFCL11
Xu146 n141 n158 VDD VSS INVR01
Xu147 n139 n159 VDD VSS INVR01
Xu148 n137 n160 VDD VSS INVR05
Xu149 n135 n161 VDD VSS INVR05
Xu15 n15 n15 n18 n18 VDD VSS MX2101
Xu150 n136 n138 n162 n139 VDD VSS MX2101
Xu151 n140 n142 n163 n143 VDD VSS MX2101
Xu152 n141 n144 n164 VSS VDD NND201
Xu153 n142 n145 n165 VSS VDD NND201
Xu154 n143 n146 n149 n158 n155 n152 n166 VSS VDD NND601
Xu155 n156 n159 n162 in3 in0 n165 n167 VSS VDD NND601
Xu156 in0 in3 n168 VDD VSS NOR200
Xu157 in0 in3 n169 VDD VSS NOR200
Xu158 in0 in3 n0 n170 VDD VSS NOR300
Xu159 in3 n0 n3 n171 VDD VSS NOR300
Xu16 in1 in2 n19 in4 VDD VSS MX2101
Xu160 n12 n9 n6 n3 n0 n172 VDD VSS NOR501
Xu161 n21 n18 n15 n12 n9 n173 VDD VSS NOR501
Xu162 n18 n21 n174 VSS VDD OR2101
Xu163 n18 n21 n175 VSS VDD OR2101
Xu164 n24 n27 n30 n176 VSS VDD ORND01
Xu165 n27 n30 n33 n177 VSS VDD ORND01
Xu166 VDD VSS VDDCON
Xu167 VDD VSS VDDCON
Xu168 n12 n15 n180 VSS VDD XNR201
Xu169 n12 n15 n181 VSS VDD XNR201
Xu17 in3 n0 n20 VSS VDD NND201
Xu170 n12 n15 n182 VSS VDD XOR201
Xu171 n12 n15 n183 VSS VDD XOR201
Xu172 n12 out0 VDD VSS CDRI01
Xu173 n9 out1 VDD VSS CDRI01
Xu174 n6 out2 VSS VDD INVR02
Xu175 n3 out3 VSS VDD INVR02
Xu176 n0 out4 VSS VDD INVR04
Xu177 in3 out5 VSS VDD INVR04
Xu178 in0 out6 VSS VDD INVR06
Xu179 out5 out7 VSS VDD INVR06
Xu18 in5 n2 n21 VSS VDD NND201
Xu19 n1 n4 n7 n16 n13 n10 n22 VSS VDD NND601
Xu2 in0 in3 n2 VSS VDD AND201
Xu20 n15 n18 n21 n0 in3 in0 n23 VSS VDD NND601
Xu21 in4 n1 n24 VDD VSS NOR200
Xu22 in5 n2 n25 VDD VSS NOR200
Xu23 n0 n3 n6 n26 VDD VSS NOR300
Xu24 n4 n7 n10 n27 VDD VSS NOR300
Xu25 n20 n17 n14 n11 n8 n28 VDD VSS NOR501
Xu26 in0 n27 n24 n21 n18 n29 VDD VSS NOR501
Xu27 n28 in0 n30 VSS VDD OR2101
Xu28 n29 in0 n31 VSS VDD OR2101
Xu29 in3 n0 n3 n32 VSS VDD ORND01
Xu3 in4 n1 n3 VSS VDD AND201
Xu30 n0 n3 n6 n33 VSS VDD ORND01
Xu31 VDD VSS VDDCON
Xu32 VDD VSS VDDCON
Xu33 n28 n31 n36 VSS VDD XNR201
Xu34 n29 n32 n37 VSS VDD XNR201
Xu35 n30 n33 n38 VSS VDD XOR201
Xu36 n31 VDD n39 VSS VDD XOR201
Xu37 n32 n40 VDD VSS CDRI01
Xu38 n30 n41 VDD VSS CDRI01
Xu39 n28 n42 VSS VDD INVR02
Xu4 in3 in0 n2 n4 VDD VSS AND301
Xu40 n26 n43 VSS VDD INVR02
Xu41 n24 n44 VSS VDD INVR04
Xu42 n22 n45 VSS VDD INVR04
Xu43 n20 n46 VSS VDD INVR06
Xu44 n18 n47 VSS VDD INVR06
Xu45 n21 n24 n27 n48 VDD VSS ADNR01
Xu46 n25 n28 n31 n49 VDD VSS ADNR01
Xu47 n24 n27 n50 VSS VDD AND201
Xu48 n25 n28 n51 VSS VDD AND201
Xu49 n32 n29 n26 n52 VDD VSS AND301
Xu5 n3 n0 in3 n5 VDD VSS AND301
Xu50 n36 n33 n30 n53 VDD VSS AND301
Xu51 n39 n42 n45 n48 n54 VDD VSS AOI401
Xu52 n46 n49 n52 in0 n55 VDD VSS AOI401
Xu53 clknet_1_1__leaf_clk n48 rst_n n57 n56 VSS VDD DFCL11
Xu54 clknet_1_1__leaf_clk n41 rst_n n59 n58 VSS VDD DFCL11
Xu55 clknet_1_1__leaf_clk VDD rst_n n61 n60 VSS VDD DFCL11
Xu56 n27 n62 VDD VSS INVR01
Xu57 n25 n63 VDD VSS INVR01
Xu58 n23 n64 VDD VSS INVR05
Xu59 n21 n65 VDD VSS INVR05
Xu6 in0 in3 n0 n3 n6 VDD VSS AOI401
Xu60 n22 n24 n66 n25 VDD VSS MX2101
Xu61 n26 n28 n67 n29 VDD VSS MX2101
Xu62 n27 n30 n68 VSS VDD NND201
Xu63 n28 n31 n69 VSS VDD NND201
Xu64 n29 n32 VDD n44 n41 n38 n70 VSS VDD NND601
Xu65 n42 n45 n48 n57 n54 n51 n71 VSS VDD NND601
Xu66 n55 n58 n72 VDD VSS NOR200
Xu67 n56 n59 n73 VDD VSS NOR200
Xu68 n57 n60 n63 n74 VDD VSS NOR300
Xu69 n61 n64 n67 n75 VDD VSS NOR300
Xu7 n2 n5 in1 in4 n7 VDD VSS AOI401
Xu70 in0 n74 n71 n68 n65 n76 VDD VSS NOR501
Xu71 n3 n0 in3 in0 n75 n77 VDD VSS NOR501
Xu72 n0 n3 n78 VSS VDD OR2101
Xu73 n0 n3 n79 VSS VDD OR2101
Xu74 n6 n9 n12 n80 VSS VDD ORND01
Xu75 n9 n12 n15 n81 VSS VDD ORND01
Xu76 VDD VSS VDDCON
Xu77 VDD VSS VDDCON
Xu78 in0 in3 n84 VSS VDD XNR201
Xu79 in0 in3 n85 VSS VDD XNR201
Xu8 clknet_1_0__leaf_clk n6 rst_n n9 n8 VSS VDD DFCL11
Xu80 in0 in3 n86 VSS VDD XOR201
Xu81 in0 in3 n87 VSS VDD XOR201
Xu82 in0 n88 VDD VSS CDRI01
Xu83 n87 n89 VDD VSS CDRI01
Xu84 n85 n90 VSS VDD INVR02
Xu85 VDD n91 VSS VDD INVR02
Xu86 n81 n92 VSS VDD INVR04
Xu87 n79 n93 VSS VDD INVR04
Xu88 n77 n94 VSS VDD INVR06
Xu89 n75 n95 VSS VDD INVR06
Xu9 clknet_1_0__leaf_clk n1 rst_n n11 n10 VSS VDD DFCL11
Xu90 n78 n81 n84 n96 VDD VSS ADNR01
Xu91 VDD n85 n88 n97 VDD VSS ADNR01
Xu92 n81 n84 n98 VSS VDD AND201
Xu93 VDD n85 n99 VSS VDD AND201
Xu94 n89 n86 VDD n100 VDD VSS AND301
Xu95 n93 n90 n87 n101 VDD VSS AND301
Xu96 n96 n99 in0 in3 n102 VDD VSS AOI401
Xu97 in0 in3 n0 n3 n103 VDD VSS AOI401
Xu98 clknet_1_0__leaf_clk in0 rst_n n105 n104 VSS VDD DFCL11
Xu99 clknet_1_1__leaf_clk n98 rst_n n107 n106 VSS VDD DFCL11
Xclkbuf_0_clk clk clknet_0_clk VDD VSS CDRI01
Xclkbuf_1_0__f_clk clknet_0_clk clknet_1_0__leaf_clk VDD VSS CDRI01
Xclkbuf_1_1__f_clk clknet_0_clk clknet_1_1__leaf_clk VDD VSS CDRI01
.ENDS libtest
