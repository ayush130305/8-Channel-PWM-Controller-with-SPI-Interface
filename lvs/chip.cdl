* OS0000 chip netlist generated by flow/assemble_chip.py
.include ../layout/frame/frame5mmx5mm_opad.cdl
.include core_cells.cdl
.include pwm8_spi_core.cir
.SUBCKT OS0000 PAD1 PAD2 PAD3 PAD4 PAD5 PAD6 PAD7 PAD8 PAD9 PAD10 PAD11 PAD12 PAD13 PAD14 PAD15 PAD16 PAD17 PAD18 PAD19 PAD20 PAD21 PAD22 PAD23 PAD24 PAD25 PAD26 PAD27 PAD28 PAD29 PAD30 PAD31 PAD32 PAD33 PAD34 PAD35 PAD36 PAD37 PAD38 PAD39 PAD40 PAD41 PAD42 PAD43 PAD44 VDD VSS
Xframe PAD1 PAD2 PAD3 PAD4 PAD5 PAD6 PAD7 PAD8 PAD9 PAD10 PAD11 PAD12 PAD13 PAD14 PAD15 PAD16 PAD17 PAD18 PAD19 PAD20 PAD21 PAD22 PAD23 PAD24 PAD25 PAD26 PAD27 PAD28 PAD29 PAD30 PAD31 PAD32 PAD33 PAD34 PAD35 PAD36 PAD37 PAD38 PAD39 PAD40 PAD41 PAD42 PAD43 PAD44 PAD2_OUT PAD4_OUT PAD6_OUT PAD8_OUT PAD10_OUT PAD12_OUT PAD14_OUT PAD16_OUT PAD18_OUT PAD20_OUT PAD22_OUT PAD24_OUT PAD26_OUT PAD28_OUT PAD30_OUT PAD32_OUT PAD34_OUT PAD36_OUT PAD38_OUT PAD40_OUT PAD42_OUT PAD44_OUT PAD1_IN PAD3_IN PAD13_IN PAD15_IN PAD17_IN PAD19_IN PAD21_IN PAD25_IN PAD27_IN PAD29_IN VDD VSS frame5mmx5mm_opad
Xcore PAD2_OUT PAD8_OUT PAD1_IN PAD10_OUT PAD4_OUT PAD6_OUT PAD3_IN PAD29_IN PAD27_IN PAD25_IN PAD21_IN PAD19_IN PAD17_IN PAD15_IN PAD13_IN VDD VSS pwm8_spi_core
.ENDS OS0000
