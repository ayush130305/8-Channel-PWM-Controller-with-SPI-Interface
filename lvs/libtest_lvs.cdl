.include core_cells.cdl
.include libtest.cir
