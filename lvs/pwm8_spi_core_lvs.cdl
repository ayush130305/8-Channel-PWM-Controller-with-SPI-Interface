.include core_cells.cdl
.include pwm8_spi_core.cir
